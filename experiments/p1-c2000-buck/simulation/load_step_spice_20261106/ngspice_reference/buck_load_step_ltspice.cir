* Ideal synchronous Buck switching-node equivalent; verified with ngspice 36.
* WSL execution and raw evidence: spice_results/ ; LTspice has not been run.
* Same teaching L/C/R, Vin, duty and 50 kHz PWM as Python fixed_duty case.
* VSW is an ideal complementary half-bridge voltage, not a MOSFET/device model.
* Signed inductor current is allowed. No dead time, losses or efficiency model.
.param VIN=9 DUTY=0.2222222222222222 TSW=20u TR=1n
VSW sw 0 PULSE(0 {VIN} 0 {TR} {TR} {DUTY*TSW-TR} {TSW})
* Pulse width subtracts TR so the area of the two finite ramps preserves mean duty.
L1 sw out 220u Rser=0 IC=0
C1 out 0 470u IC=0
RLOAD out 0 4
* Open-loop load step: parallel added 4-ohm conductance at 50 ms.
BSTEP out 0 I=V(out)*(time>=50m)/4
.tran 0.25u 100m 49.6m 0.25u uic
.meas tran pre_vout_mean AVG V(out) FROM=49.6m TO=50m
.meas tran pre_il_mean AVG I(L1) FROM=49.6m TO=50m
.meas tran post_vout_mean AVG V(out) FROM=99.6m TO=100m
.meas tran post_il_mean AVG I(L1) FROM=99.6m TO=100m
.end
