Independent ideal Buck startup and 4-to-2-ohm load step; LTspice execution pending
* Fixed duty, NOT a closed-loop PI or soft-start simulation.
* L/C start at zero. Signed current/voltage are allowed by this ideal model.
.param VIN=9 DUTY=0.2222222222222222 TSW=20u TR=1n
VSW sw 0 PULSE(0 {VIN} 0 {TR} {TR} {DUTY*TSW-TR} {TSW})
L1 sw out 220u Rser=0 IC=0
C1 out 0 470u IC=0
BLOAD out 0 I=V(out)*if(time<50m,0.25,0.5)
.options plotwinsize=0 reltol=1e-6
.save V(sw) V(out) I(L1)
.tran 0 60m 0 0.25u uic
.meas tran startup_peak MAX V(out) FROM=0 TO=20m
.meas tran before_step AVG V(out) FROM=49m TO=50m
.meas tran after_step AVG V(out) FROM=59m TO=60m
.end
