Independent ideal low-voltage Buck; LTspice execution pending
* Teaching model, not the TI circuit. No device losses or dead time.
.param VIN=9 DUTY=0.2222222222222222 TSW=20u TR=1n
VSW sw 0 PULSE(0 {VIN} 0 {TR} {TR} {DUTY*TSW-TR} {TSW})
L1 sw out 220u Rser=0 IC=0
C1 out 0 470u IC=0
RLOAD out 0 4
.options plotwinsize=0 reltol=1e-6
.save V(sw) V(out) I(L1)
.tran 0 60m 59.6m 0.25u uic
.meas tran vout_mean AVG V(out) FROM=59.6m TO=60m
.meas tran il_mean AVG I(L1) FROM=59.6m TO=60m
.meas tran vout_pp PP V(out) FROM=59.6m TO=60m
.meas tran il_pp PP I(L1) FROM=59.6m TO=60m
.end
